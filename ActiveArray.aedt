# Ansys Electronics Desktop project, version 2025.2
project variables:
  $RIGHT_X = 0.13meter
  $LEFT_X = 0mm
  $BOTTOM_Y = 0m
  $TOP_Y = 0.1256meter
  $FR4_THICKNESS = 0.0016meter
  $PATCH_WIDTH = 28.42mm
  $PATCH_HEIGHT = 36.74mm
  $PATCH_1_X = 0.02
  $PATCH_1_Y = 0.0128
  $FEED_THICKNESS = 2.377mm
  $INSET = -8mm
  $INSET_H = $INSET+.003
materials:
  vacuum: permittivity=1
  FR4_epoxy: permittivity=4.4 dielectric_loss_tangent=0.02

design FourCorners (HFSS, HFSS Modal Network, model units mm)
geometry:
  pcb [FR4_epoxy] = box(corner=($LEFT_X, $BOTTOM_Y, 0mm), size=($RIGHT_X-$LEFT_X, $TOP_Y-$BOTTOM_Y, $FR4_THICKNESS))
  patch1 = rectangle(corner=($LEFT_X+$PATCH_1_X, $BOTTOM_Y+$PATCH_1_Y, $FR4_THICKNESS), x_size=$PATCH_WIDTH, y_size=$PATCH_HEIGHT)
  Rectangle15 = rectangle(corner=(0, $PATCH_HEIGHT/2-$INSET_H/2, 0mm), x_size=-$INSET, y_size=$INSET_H) in PatchCS1
  patch1.subtract(Rectangle15)
  Feed1 = rectangle(corner=(-$INSET, $PATCH_HEIGHT/2-$FEED_THICKNESS/2, 0), x_size=-$PATCH_1_X + $INSET, y_size=$FEED_THICKNESS) in PatchCS1
  coordinate_system PatchCS1 = object of patch1: Origin=(20, 12.8, 1.6) xAxis{xDirection=1 yDirection=0 zDirection=0} yAxis{xDirection=0 yDirection=1 zDirection=0}
  Box1 [vacuum] = box(corner=($LEFT_X-.03, $BOTTOM_Y-0.03, -0.03), size=($RIGHT_X-$LEFT_X+0.06, $TOP_Y-$BOTTOM_Y+0.06, 0.06meter))
  gnd = rectangle(corner=($LEFT_X, $BOTTOM_Y, 0mm), x_size=$RIGHT_X-$LEFT_X, y_size=$TOP_Y-$BOTTOM_Y)
  coordinate_system RelativeCS1 = origin=(-$PATCH_1_X, $PATCH_HEIGHT/2-$FEED_THICKNESS/2, 0) x=(1mm, 0mm, 0mm) y=(0mm, 1mm, 0mm) in PatchCS1
  Port1 = rectangle(corner=(0mm, $FEED_THICKNESS, 0mm), y_size=-$FEED_THICKNESS, z_size=-$FR4_THICKNESS) in RelativeCS1
  coordinate_system ShiftUp62.5 = origin=(0mm, 62.5mm, 0mm) x=(1mm, 0mm, 0mm) y=(0mm, 1mm, 0mm)
  patch4 = rectangle(corner=($LEFT_X+$PATCH_1_X, $BOTTOM_Y+$PATCH_1_Y, $FR4_THICKNESS), x_size=$PATCH_WIDTH, y_size=$PATCH_HEIGHT) in ShiftUp62.5
  Rectangle19 = rectangle(corner=(0, $PATCH_HEIGHT/2-$INSET_H/2, 0mm), x_size=-$INSET, y_size=$INSET_H) in PatchCS2
  patch4.subtract(Rectangle19)
  Feed2 = rectangle(corner=(-$INSET, $PATCH_HEIGHT/2-$FEED_THICKNESS/2, 0), x_size=-$PATCH_1_X + $INSET, y_size=$FEED_THICKNESS) in PatchCS2
  coordinate_system RelativeCS3 = origin=(-$PATCH_1_X, $PATCH_HEIGHT/2-$FEED_THICKNESS/2, 0) x=(1mm, 0mm, 0mm) y=(0mm, 1mm, 0mm) in PatchCS2
  Port2 = rectangle(corner=(0mm, $FEED_THICKNESS, 0mm), y_size=-$FEED_THICKNESS, z_size=-$FR4_THICKNESS) in RelativeCS3
  coordinate_system PatchCS2 = object of patch4: Origin=(20, 75.3, 1.6) xAxis{xDirection=1 yDirection=0 zDirection=0} yAxis{xDirection=0 yDirection=1 zDirection=0} in ShiftUp62.5
  coordinate_system ShiftX = origin=($RIGHT_X, 0mm, 0mm) x=(1mm, 0mm, 0mm) y=(0mm, 1mm, 0mm)
  patch5 = rectangle(corner=($LEFT_X+$PATCH_1_X, $BOTTOM_Y+$PATCH_1_Y, $FR4_THICKNESS), x_size=$PATCH_WIDTH, y_size=$PATCH_HEIGHT) in ShiftX
  Rectangle20 = rectangle(corner=(0, $PATCH_HEIGHT/2-$INSET_H/2, 0mm), x_size=-$INSET, y_size=$INSET_H) in PatchCS3
  patch5.subtract(Rectangle20)
  Feed3 = rectangle(corner=(-$INSET, $PATCH_HEIGHT/2-$FEED_THICKNESS/2, 0), x_size=-$PATCH_1_X + $INSET, y_size=$FEED_THICKNESS) in PatchCS3
  coordinate_system RelativeCS5 = origin=(-$PATCH_1_X, $PATCH_HEIGHT/2-$FEED_THICKNESS/2, 0) x=(1mm, 0mm, 0mm) y=(0mm, 1mm, 0mm) in PatchCS3
  Port3 = rectangle(corner=(0mm, $FEED_THICKNESS, 0mm), y_size=-$FEED_THICKNESS, z_size=-$FR4_THICKNESS) in RelativeCS5
  coordinate_system ShiftUp62.6 = origin=(0mm, 62.5mm, 0mm) x=(1mm, 0mm, 0mm) y=(0mm, 1mm, 0mm) in ShiftX
  patch6 = rectangle(corner=($LEFT_X+$PATCH_1_X, $BOTTOM_Y+$PATCH_1_Y, $FR4_THICKNESS), x_size=$PATCH_WIDTH, y_size=$PATCH_HEIGHT) in ShiftUp62.6
  Rectangle21 = rectangle(corner=(0, $PATCH_HEIGHT/2-$INSET_H/2, 0mm), x_size=-$INSET, y_size=$INSET_H) in PatchCS4
  patch6.subtract(Rectangle21)
  Feed4 = rectangle(corner=(-$INSET, $PATCH_HEIGHT/2-$FEED_THICKNESS/2, 0), x_size=-$PATCH_1_X + $INSET, y_size=$FEED_THICKNESS) in PatchCS4
  coordinate_system RelativeCS6 = origin=(-$PATCH_1_X, $PATCH_HEIGHT/2-$FEED_THICKNESS/2, 0) x=(1mm, 0mm, 0mm) y=(0mm, 1mm, 0mm) in PatchCS4
  Port4 = rectangle(corner=(0mm, $FEED_THICKNESS, 0mm), y_size=-$FEED_THICKNESS, z_size=-$FR4_THICKNESS) in RelativeCS6
  coordinate_system PatchCS3 = object of patch5: Origin=(150, 12.8, 1.6) xAxis{xDirection=1 yDirection=0 zDirection=0} yAxis{xDirection=0 yDirection=1 zDirection=0} in ShiftX
  coordinate_system PatchCS4 = object of patch6: Origin=(150, 75.3, 1.6) xAxis{xDirection=1 yDirection=0 zDirection=0} yAxis{xDirection=0 yDirection=1 zDirection=0} in ShiftUp62.6
  [Port3, Port4, patch5, patch6, Feed3, Feed4].mirror(point=(0mm, 25.5615mm, 1.6mm), normal=(1mm, 0mm, 2.3373116e-17mm)) in ShiftX
boundaries and excitations:
  PerfE1: Perfect E Objects=[Feed1, patch1]
  Rad1: Radiation Objects=Box1
  PerfE2: Perfect E Objects=gnd
  PerfE3: Perfect E Objects=[Feed2, patch4]
  PerfE4: Perfect E Objects=[Feed3, patch5]
  PerfE5: Perfect E Objects=[Feed4, patch6]
  1: Lumped Port Objects=Port1 LumpedPortType=Modal Modes{Mode1{IntLine{(0, 31.17, 0) -> (0, 31.17, 1.6)} CharImp=Zpi}} Impedance=50ohm
  2: Lumped Port Objects=Port2 LumpedPortType=Modal Modes{Mode1{IntLine{(0, 93.67, 0) -> (0, 93.67, 1.6)} CharImp=Zpi}} Impedance=50ohm
  3: Lumped Port Objects=Port3 LumpedPortType=Modal Modes{Mode1{IntLine{(130, 31.17, 0) -> (130, 31.17, 1.6)} CharImp=Zpi}} Impedance=50ohm
  4: Lumped Port Objects=Port4 LumpedPortType=Modal Modes{Mode1{IntLine{(130, 93.67, 0) -> (130, 93.67, 1.6)} CharImp=Zpi}} Impedance=50ohm
setups:
  Setup1: HfssDriven Frequency=2.4GHz MaxDeltaS=0.02 MaximumPasses=15 MinimumPasses=1 MinimumConvergedPasses=1 PercentRefinement=30 BasisOrder=1 PortAccuracy=2 DrivenSolverType="Direct Solver"
    sweep Sweep: 1.6GHz to 3.6GHz, 200 points; Type=Interpolating InterpTolerance=0.5 InterpMaxSolns=250 InterpUsePortImped=false PassivityErrorTolerance=0.0001
source amplitudes:
  1:1, 2:1, 3:1, 4:1: 1W 90deg
radiation setups:
  Infinite Sphere1: Infinite Sphere Theta=0deg..180deg step 10deg Phi=0deg..360deg step 10deg
field plots:
  Mag_E1: E Field over gnd.face on Setup1 : LastAdaptive at Freq=2.4GHz Phase=0deg
  Mag_E2: E Field over Feed1.face Feed2.face Feed3.face(at (116, 31.17, 1.6)) Feed4.face(at (116, 93.67, 1.6)) gnd.face patch1.face(at (34.21, 31.17, 1.6)) patch4.face(at (34.21, 93.67, 1.6)) patch5.face(at (95.79, 31.17, 1.6)) patch6.face(at (95.79, 93.67, 1.6)) on Setup1 : LastAdaptive at Freq=2.4GHz Phase=0deg
reports:
  S Parameter Plot1: dB(S(1,1)), dB(S(2,2)), dB(S(3,3)), dB(S(4,4)) vs Freq on Setup1 : Sweep
  Z Parameter Plot1: im(Z(1,1)), re(Z(1,1)), im(Z(1,1)), re(Z(2,2)), im(Z(2,2)), re(Z(3,3)), im(Z(3,3)), re(Z(4,4)), im(Z(4,4)) vs Freq on Setup1 : Sweep [$INSET=all]
  Gain Plot1: GainTotal vs Phi, Theta on Setup1 : LastAdaptive, Infinite Sphere1 [Freq=2.4GHz]
  Mutual Coupling: dB(S(2,1)), dB(S(3,1)), dB(S(4,1)), dB(S(3,2)), dB(S(4,2)), dB(S(4,3)) vs Freq on Setup1 : Sweep [$PATCH_WIDTH=all $PATCH_HEIGHT=all]
